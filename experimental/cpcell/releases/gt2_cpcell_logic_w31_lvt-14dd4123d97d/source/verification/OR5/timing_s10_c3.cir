CPCell GT2N logic characterization
.MODEL nmos_lvt NMOS l=1.4e-08
+delvtrand=0.0941939
+ids0mult=1.0
+DEVTYPE=1
+EASUB=4.0727
+NI0SUB=1.1055e+16
+BG0SUB=1.1242
+NC0SUB=2.9951e+25
+eot=7e-10
+phig=4.35089
+RDSW=0
+RDSWMIN=0
+cdscd=0.0182693
+vsat=278640
+VSAT1=26297.8352
+u0=0.00655832
+ua=0.47704
+PDIBL2=4.76650442e-11
+pclm=0.0785116
+pclmg=1.48901e-05
+level=110
+VERSION=111
+BULKMOD=0
+CAPMOD=1
+IGCMOD=0
+IGBMOD=0
+GIDLMOD=0
+COREMOD=0
+GEOMOD=2
+CGEOMOD=0
+IIMOD=0
+RDSMOD=0
+tnom=25
+XL=0
+LINT=0
+LL=0
+LLC=0
+LLN=1
+dlc=-7.20077e-09
+tfin=5e-09
+hfin=3.1e-08
+FPITCH=3e-08
+FECH=1
+NF=1
+NFIN=3
+NBODY=2e+20
+NSD=2e+26
+NGATE=0
+LPHIG=0
+LRDSW=0
+ARDSW=0
+BRDSW=1e-08
+PRWG=0
+CIT=0
+cdsc=0.0824961
+LCDSC=0
+LCDSCD=0
+DVT0=0
+LDVT0=0
+DVT1=0.7
+LDVT1=0
+PHIN=0
+LPHIN=0
+eta0=0
+LETA0=0
+DSUB=1.06
+LDSUB=0
+K1RSCE=0
+LK1RSCE=0
+LPE0=0
+LLPE0=0
+QMFACTOR=1
+qm0=3.2146
+LVSAT=0
+AVSAT=0
+BVSAT=6e-08
+AVSAT1=0
+BVSAT1=6e-08
+ksativ=1.45222
+LKSATIV=0
+DELTAVSAT=1
+MEXP=2.57453964
+LMEXP=0
+AMEXP=0
+BMEXP=1
+PTWG=2.01398393
+LPTWG=0
+APTWG=0
+BPTWG=6e-08
+LU0=0
+etamob=1.7466
+UP=0
+LUP=0
+LPA=1
+LUA=0
+AUA=0
+BUA=6e-08
+eu=1.43089
+LEU=0
+ud=0
+LUD=0
+AUD=0
+BUD=5e-08
+UCS=1
+LUCS=0
+PDIBL1=0
+LPDIBL1=0
+LPDIBL2=0
+DROUT=1.06
+LDROUT=0
+pvag=0.399363
+LPVAG=0
+LPCLM=0
+cfs=1.23498e-14
+PRWGS=1
+at=0.00106028
+cfd=1.23498e-14
+cgdl=1.27652e-10
+cgdo=0
+cgsl=1.27652e-10
+cgso=0
+ckappad=0.44752
+ckappas=0.44752
+dvtp0=-0.00405049
+dvtp1=1
+iit=0
+kt1=-0.0929644
+lsp=6e-09
+pqm=0.421985
+prt=0
+ptwgt=0
+qmtcencv=1.54323
+tss=-0.000166334
+ua1=-0.00047238
+uc1=0
+ucste=0
+ute=-1.08377
+utl=0

.MODEL pmos_lvt PMOS l=1.4e-08
+delvtrand=-0.0162038
+ids0mult=1.0
+DEVTYPE=0
+EASUB=4.0727
+NI0SUB=1.1055e+16
+BG0SUB=1.1242
+NC0SUB=2.9951e+25
+phig=4.9565
+eot=7e-10
+RDSW=0
+RDSWMIN=0
+cdscd=0.00736551
+vsat=62793.4
+VSAT1=18420.44
+u0=0.00861088
+ua=0.614716
+PDIBL2=0.0187387234
+pclm=0.0452374
+pclmg=0.112293
+CHARGEWF=0
+level=110
+VERSION=111
+BULKMOD=0
+CAPMOD=1
+IGCMOD=0
+IGBMOD=0
+GIDLMOD=0
+COREMOD=0
+GEOMOD=2
+CGEOMOD=0
+IIMOD=0
+RDSMOD=0
+tnom=25
+XL=0
+LINT=0
+LL=0
+LLC=0
+LLN=1
+dlc=-3.96294e-09
+tfin=5e-09
+hfin=3.1e-08
+FPITCH=3e-08
+FECH=1
+NF=1
+NFIN=3
+NBODY=2e+20
+NSD=2e+26
+NGATE=0
+LPHIG=0
+LRDSW=0
+ARDSW=0
+BRDSW=1e-08
+PRWG=0
+CIT=0
+cdsc=0.204214
+LCDSC=0
+LCDSCD=0
+DVT0=0
+LDVT0=0
+DVT1=0.7
+LDVT1=0
+PHIN=0
+LPHIN=0
+eta0=0
+LETA0=0
+DSUB=1.06
+LDSUB=0
+K1RSCE=0
+LK1RSCE=0
+LPE0=0
+LLPE0=0
+QMFACTOR=1
+qm0=3.48063
+LVSAT=0
+AVSAT=0
+BVSAT=6e-08
+AVSAT1=0
+BVSAT1=6e-08
+ksativ=2.02852
+LKSATIV=0
+DELTAVSAT=1
+MEXP=3.16898086
+LMEXP=0
+AMEXP=0
+BMEXP=1
+PTWG=1.00115196e-05
+LPTWG=0
+APTWG=0
+BPTWG=6e-08
+LU0=0
+etamob=2.12953
+UP=0
+LUP=0
+LPA=1
+LUA=0
+AUA=0
+BUA=6e-08
+eu=0.77307
+LEU=0
+ud=0
+LUD=0
+AUD=0
+BUD=5e-08
+UCS=1
+LUCS=0
+PDIBL1=0
+LPDIBL1=0
+LPDIBL2=0
+DROUT=1.06
+LDROUT=0
+pvag=22.72
+LPVAG=0
+LPCLM=0
+cfs=9.10016e-11
+PRWGS=1
+at=-0.000202066
+cfd=9.10016e-11
+cgdl=8.13182e-11
+cgdo=0
+cgsl=8.13182e-11
+cgso=0
+ckappad=0.277205
+ckappas=0.277205
+dvtp0=-0.0119321
+dvtp1=1
+iit=0
+kt1=0.0175865
+lsp=6e-09
+pqm=1.44515
+prt=0
+ptwgt=0
+qmtcencv=1.2799
+tss=-0.000168939
+ua1=-0.00129039
+uc1=0
+ucste=0
+ute=-0.537203
+utl=-1.39354e-05

.SUBCKT gt2_6t_or5_w31_lvt A B C D E Y vdd vss
MN0 Z A vss vss nmos_lvt L=0.014u
MN1 Z B vss vss nmos_lvt L=0.014u
MN2 Z C vss vss nmos_lvt L=0.014u
MN3 Z D vss vss nmos_lvt L=0.014u
MN4 Z E vss vss nmos_lvt L=0.014u
MP0 Z A P1 vdd pmos_lvt L=0.014u
MP1 P1 B P2 vdd pmos_lvt L=0.014u
MP2 P2 C P3 vdd pmos_lvt L=0.014u
MP3 P3 D P4 vdd pmos_lvt L=0.014u
MP4 P4 E vdd vdd pmos_lvt L=0.014u
MINV_N Y Z vss vss nmos_lvt L=0.014u
MINV_P Y Z vdd vdd pmos_lvt L=0.014u
.ENDS gt2_6t_or5_w31_lvt

.TEMP 25
VDD vdd 0 0.7
VIN0 in0 0 PWL(0 0 2e-10 0 2.16667e-10 0.7 6e-10 0.7 6.16667e-10 0)
X0 in0 0 0 0 0 y0 vdd 0 gt2_6t_or5_w31_lvt
CL0 y0 0 3f
VIN1 in1 0 PWL(0 0 2e-10 0 2.16667e-10 0.7 6e-10 0.7 6.16667e-10 0)
X1 0 in1 0 0 0 y1 vdd 0 gt2_6t_or5_w31_lvt
CL1 y1 0 3f
VIN2 in2 0 PWL(0 0 2e-10 0 2.16667e-10 0.7 6e-10 0.7 6.16667e-10 0)
X2 0 0 in2 0 0 y2 vdd 0 gt2_6t_or5_w31_lvt
CL2 y2 0 3f
VIN3 in3 0 PWL(0 0 2e-10 0 2.16667e-10 0.7 6e-10 0.7 6.16667e-10 0)
X3 0 0 0 in3 0 y3 vdd 0 gt2_6t_or5_w31_lvt
CL3 y3 0 3f
VIN4 in4 0 PWL(0 0 2e-10 0 2.16667e-10 0.7 6e-10 0.7 6.16667e-10 0)
X4 0 0 0 0 in4 y4 vdd 0 gt2_6t_or5_w31_lvt
CL4 y4 0 3f
.TRAN 0.5p 1n 0 1p
.PRINT TRAN FORMAT=CSV V(in0) V(y0) I(VIN0) V(in1) V(y1) I(VIN1) V(in2) V(y2) I(VIN2) V(in3) V(y3) I(VIN3) V(in4) V(y4) I(VIN4)
.END
