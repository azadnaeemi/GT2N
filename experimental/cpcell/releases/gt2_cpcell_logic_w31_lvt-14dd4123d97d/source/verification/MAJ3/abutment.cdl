.SUBCKT gt2_6t_maj3_w31_lvt A B C Y vdd vss
MNAB0 Z A NAB1 vss nmos_lvt W=0.031u L=0.014u M=1
MNAB1 NAB1 B vss vss nmos_lvt W=0.031u L=0.014u M=1
MNC Z C N1 vss nmos_lvt W=0.031u L=0.014u M=1
MNP0 N1 A vss vss nmos_lvt W=0.031u L=0.014u M=1
MNP1 N1 B vss vss nmos_lvt W=0.031u L=0.014u M=1
MPP0 Z A P1 vdd pmos_lvt W=0.031u L=0.014u M=1
MPP1 Z B P1 vdd pmos_lvt W=0.031u L=0.014u M=1
MPC P1 C vdd vdd pmos_lvt W=0.031u L=0.014u M=1
MPAB0 P1 A PAB1 vdd pmos_lvt W=0.031u L=0.014u M=1
MPAB1 PAB1 B vdd vdd pmos_lvt W=0.031u L=0.014u M=1
MINV_N Y Z vss vss nmos_lvt W=0.031u L=0.014u M=1
MINV_P Y Z vdd vdd pmos_lvt W=0.031u L=0.014u M=1
.ENDS gt2_6t_maj3_w31_lvt

.SUBCKT gt2_6t_maj3_w31_lvt_abut A_0_0 B_0_0 C_0_0 Y_0_0 A_1_0 B_1_0 C_1_0 Y_1_0 A_0_1 B_0_1 C_0_1 Y_0_1 A_1_1 B_1_1 C_1_1 Y_1_1 vdd vss
X00 A_0_0 B_0_0 C_0_0 Y_0_0 vdd vss gt2_6t_maj3_w31_lvt
X10 A_1_0 B_1_0 C_1_0 Y_1_0 vdd vss gt2_6t_maj3_w31_lvt
X01 A_0_1 B_0_1 C_0_1 Y_0_1 vdd vss gt2_6t_maj3_w31_lvt
X11 A_1_1 B_1_1 C_1_1 Y_1_1 vdd vss gt2_6t_maj3_w31_lvt
.ENDS gt2_6t_maj3_w31_lvt_abut
