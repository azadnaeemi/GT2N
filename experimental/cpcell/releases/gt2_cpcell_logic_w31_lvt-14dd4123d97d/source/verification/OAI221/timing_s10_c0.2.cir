CPCell GT2N logic characterization
.MODEL nmos_lvt NMOS l=1.4e-08
+delvtrand=0.0941939
+ids0mult=1.0
+DEVTYPE=1
+EASUB=4.0727
+NI0SUB=1.1055e+16
+BG0SUB=1.1242
+NC0SUB=2.9951e+25
+eot=7e-10
+phig=4.35089
+RDSW=0
+RDSWMIN=0
+cdscd=0.0182693
+vsat=278640
+VSAT1=26297.8352
+u0=0.00655832
+ua=0.47704
+PDIBL2=4.76650442e-11
+pclm=0.0785116
+pclmg=1.48901e-05
+level=110
+VERSION=111
+BULKMOD=0
+CAPMOD=1
+IGCMOD=0
+IGBMOD=0
+GIDLMOD=0
+COREMOD=0
+GEOMOD=2
+CGEOMOD=0
+IIMOD=0
+RDSMOD=0
+tnom=25
+XL=0
+LINT=0
+LL=0
+LLC=0
+LLN=1
+dlc=-7.20077e-09
+tfin=5e-09
+hfin=3.1e-08
+FPITCH=3e-08
+FECH=1
+NF=1
+NFIN=3
+NBODY=2e+20
+NSD=2e+26
+NGATE=0
+LPHIG=0
+LRDSW=0
+ARDSW=0
+BRDSW=1e-08
+PRWG=0
+CIT=0
+cdsc=0.0824961
+LCDSC=0
+LCDSCD=0
+DVT0=0
+LDVT0=0
+DVT1=0.7
+LDVT1=0
+PHIN=0
+LPHIN=0
+eta0=0
+LETA0=0
+DSUB=1.06
+LDSUB=0
+K1RSCE=0
+LK1RSCE=0
+LPE0=0
+LLPE0=0
+QMFACTOR=1
+qm0=3.2146
+LVSAT=0
+AVSAT=0
+BVSAT=6e-08
+AVSAT1=0
+BVSAT1=6e-08
+ksativ=1.45222
+LKSATIV=0
+DELTAVSAT=1
+MEXP=2.57453964
+LMEXP=0
+AMEXP=0
+BMEXP=1
+PTWG=2.01398393
+LPTWG=0
+APTWG=0
+BPTWG=6e-08
+LU0=0
+etamob=1.7466
+UP=0
+LUP=0
+LPA=1
+LUA=0
+AUA=0
+BUA=6e-08
+eu=1.43089
+LEU=0
+ud=0
+LUD=0
+AUD=0
+BUD=5e-08
+UCS=1
+LUCS=0
+PDIBL1=0
+LPDIBL1=0
+LPDIBL2=0
+DROUT=1.06
+LDROUT=0
+pvag=0.399363
+LPVAG=0
+LPCLM=0
+cfs=1.23498e-14
+PRWGS=1
+at=0.00106028
+cfd=1.23498e-14
+cgdl=1.27652e-10
+cgdo=0
+cgsl=1.27652e-10
+cgso=0
+ckappad=0.44752
+ckappas=0.44752
+dvtp0=-0.00405049
+dvtp1=1
+iit=0
+kt1=-0.0929644
+lsp=6e-09
+pqm=0.421985
+prt=0
+ptwgt=0
+qmtcencv=1.54323
+tss=-0.000166334
+ua1=-0.00047238
+uc1=0
+ucste=0
+ute=-1.08377
+utl=0

.MODEL pmos_lvt PMOS l=1.4e-08
+delvtrand=-0.0162038
+ids0mult=1.0
+DEVTYPE=0
+EASUB=4.0727
+NI0SUB=1.1055e+16
+BG0SUB=1.1242
+NC0SUB=2.9951e+25
+phig=4.9565
+eot=7e-10
+RDSW=0
+RDSWMIN=0
+cdscd=0.00736551
+vsat=62793.4
+VSAT1=18420.44
+u0=0.00861088
+ua=0.614716
+PDIBL2=0.0187387234
+pclm=0.0452374
+pclmg=0.112293
+CHARGEWF=0
+level=110
+VERSION=111
+BULKMOD=0
+CAPMOD=1
+IGCMOD=0
+IGBMOD=0
+GIDLMOD=0
+COREMOD=0
+GEOMOD=2
+CGEOMOD=0
+IIMOD=0
+RDSMOD=0
+tnom=25
+XL=0
+LINT=0
+LL=0
+LLC=0
+LLN=1
+dlc=-3.96294e-09
+tfin=5e-09
+hfin=3.1e-08
+FPITCH=3e-08
+FECH=1
+NF=1
+NFIN=3
+NBODY=2e+20
+NSD=2e+26
+NGATE=0
+LPHIG=0
+LRDSW=0
+ARDSW=0
+BRDSW=1e-08
+PRWG=0
+CIT=0
+cdsc=0.204214
+LCDSC=0
+LCDSCD=0
+DVT0=0
+LDVT0=0
+DVT1=0.7
+LDVT1=0
+PHIN=0
+LPHIN=0
+eta0=0
+LETA0=0
+DSUB=1.06
+LDSUB=0
+K1RSCE=0
+LK1RSCE=0
+LPE0=0
+LLPE0=0
+QMFACTOR=1
+qm0=3.48063
+LVSAT=0
+AVSAT=0
+BVSAT=6e-08
+AVSAT1=0
+BVSAT1=6e-08
+ksativ=2.02852
+LKSATIV=0
+DELTAVSAT=1
+MEXP=3.16898086
+LMEXP=0
+AMEXP=0
+BMEXP=1
+PTWG=1.00115196e-05
+LPTWG=0
+APTWG=0
+BPTWG=6e-08
+LU0=0
+etamob=2.12953
+UP=0
+LUP=0
+LPA=1
+LUA=0
+AUA=0
+BUA=6e-08
+eu=0.77307
+LEU=0
+ud=0
+LUD=0
+AUD=0
+BUD=5e-08
+UCS=1
+LUCS=0
+PDIBL1=0
+LPDIBL1=0
+LPDIBL2=0
+DROUT=1.06
+LDROUT=0
+pvag=22.72
+LPVAG=0
+LPCLM=0
+cfs=9.10016e-11
+PRWGS=1
+at=-0.000202066
+cfd=9.10016e-11
+cgdl=8.13182e-11
+cgdo=0
+cgsl=8.13182e-11
+cgso=0
+ckappad=0.277205
+ckappas=0.277205
+dvtp0=-0.0119321
+dvtp1=1
+iit=0
+kt1=0.0175865
+lsp=6e-09
+pqm=1.44515
+prt=0
+ptwgt=0
+qmtcencv=1.2799
+tss=-0.000168939
+ua1=-0.00129039
+uc1=0
+ucste=0
+ute=-0.537203
+utl=-1.39354e-05

.SUBCKT gt2_6t_oai221_w31_lvt A1 A2 B1 B2 C Y vdd vss
MNA0 Y A1 N1 vss nmos_lvt L=0.014u
MNA1 Y A2 N1 vss nmos_lvt L=0.014u
MNB0 N1 B1 N2 vss nmos_lvt L=0.014u
MNB1 N1 B2 N2 vss nmos_lvt L=0.014u
MNC N2 C vss vss nmos_lvt L=0.014u
MPA0 Y A1 PA1 vdd pmos_lvt L=0.014u
MPA1 PA1 A2 vdd vdd pmos_lvt L=0.014u
MPB0 Y B1 PB1 vdd pmos_lvt L=0.014u
MPB1 PB1 B2 vdd vdd pmos_lvt L=0.014u
MPC Y C vdd vdd pmos_lvt L=0.014u
.ENDS gt2_6t_oai221_w31_lvt

.TEMP 25
VDD vdd 0 0.7
VIN0 in0 0 PWL(0 0 2e-10 0 2.16667e-10 0.7 6e-10 0.7 6.16667e-10 0)
X0 in0 0 0 vdd vdd y0 vdd 0 gt2_6t_oai221_w31_lvt
CL0 y0 0 0.2f
VIN1 in1 0 PWL(0 0 2e-10 0 2.16667e-10 0.7 6e-10 0.7 6.16667e-10 0)
X1 in1 0 vdd 0 vdd y1 vdd 0 gt2_6t_oai221_w31_lvt
CL1 y1 0 0.2f
VIN2 in2 0 PWL(0 0 2e-10 0 2.16667e-10 0.7 6e-10 0.7 6.16667e-10 0)
X2 in2 0 vdd vdd vdd y2 vdd 0 gt2_6t_oai221_w31_lvt
CL2 y2 0 0.2f
VIN3 in3 0 PWL(0 0 2e-10 0 2.16667e-10 0.7 6e-10 0.7 6.16667e-10 0)
X3 0 in3 0 vdd vdd y3 vdd 0 gt2_6t_oai221_w31_lvt
CL3 y3 0 0.2f
VIN4 in4 0 PWL(0 0 2e-10 0 2.16667e-10 0.7 6e-10 0.7 6.16667e-10 0)
X4 0 in4 vdd 0 vdd y4 vdd 0 gt2_6t_oai221_w31_lvt
CL4 y4 0 0.2f
VIN5 in5 0 PWL(0 0 2e-10 0 2.16667e-10 0.7 6e-10 0.7 6.16667e-10 0)
X5 0 in5 vdd vdd vdd y5 vdd 0 gt2_6t_oai221_w31_lvt
CL5 y5 0 0.2f
VIN6 in6 0 PWL(0 0 2e-10 0 2.16667e-10 0.7 6e-10 0.7 6.16667e-10 0)
X6 0 vdd in6 0 vdd y6 vdd 0 gt2_6t_oai221_w31_lvt
CL6 y6 0 0.2f
VIN7 in7 0 PWL(0 0 2e-10 0 2.16667e-10 0.7 6e-10 0.7 6.16667e-10 0)
X7 vdd 0 in7 0 vdd y7 vdd 0 gt2_6t_oai221_w31_lvt
CL7 y7 0 0.2f
VIN8 in8 0 PWL(0 0 2e-10 0 2.16667e-10 0.7 6e-10 0.7 6.16667e-10 0)
X8 vdd vdd in8 0 vdd y8 vdd 0 gt2_6t_oai221_w31_lvt
CL8 y8 0 0.2f
VIN9 in9 0 PWL(0 0 2e-10 0 2.16667e-10 0.7 6e-10 0.7 6.16667e-10 0)
X9 0 vdd 0 in9 vdd y9 vdd 0 gt2_6t_oai221_w31_lvt
CL9 y9 0 0.2f
VIN10 in10 0 PWL(0 0 2e-10 0 2.16667e-10 0.7 6e-10 0.7 6.16667e-10 0)
X10 vdd 0 0 in10 vdd y10 vdd 0 gt2_6t_oai221_w31_lvt
CL10 y10 0 0.2f
VIN11 in11 0 PWL(0 0 2e-10 0 2.16667e-10 0.7 6e-10 0.7 6.16667e-10 0)
X11 vdd vdd 0 in11 vdd y11 vdd 0 gt2_6t_oai221_w31_lvt
CL11 y11 0 0.2f
VIN12 in12 0 PWL(0 0 2e-10 0 2.16667e-10 0.7 6e-10 0.7 6.16667e-10 0)
X12 0 vdd 0 vdd in12 y12 vdd 0 gt2_6t_oai221_w31_lvt
CL12 y12 0 0.2f
VIN13 in13 0 PWL(0 0 2e-10 0 2.16667e-10 0.7 6e-10 0.7 6.16667e-10 0)
X13 0 vdd vdd 0 in13 y13 vdd 0 gt2_6t_oai221_w31_lvt
CL13 y13 0 0.2f
VIN14 in14 0 PWL(0 0 2e-10 0 2.16667e-10 0.7 6e-10 0.7 6.16667e-10 0)
X14 0 vdd vdd vdd in14 y14 vdd 0 gt2_6t_oai221_w31_lvt
CL14 y14 0 0.2f
VIN15 in15 0 PWL(0 0 2e-10 0 2.16667e-10 0.7 6e-10 0.7 6.16667e-10 0)
X15 vdd 0 0 vdd in15 y15 vdd 0 gt2_6t_oai221_w31_lvt
CL15 y15 0 0.2f
VIN16 in16 0 PWL(0 0 2e-10 0 2.16667e-10 0.7 6e-10 0.7 6.16667e-10 0)
X16 vdd 0 vdd 0 in16 y16 vdd 0 gt2_6t_oai221_w31_lvt
CL16 y16 0 0.2f
VIN17 in17 0 PWL(0 0 2e-10 0 2.16667e-10 0.7 6e-10 0.7 6.16667e-10 0)
X17 vdd 0 vdd vdd in17 y17 vdd 0 gt2_6t_oai221_w31_lvt
CL17 y17 0 0.2f
VIN18 in18 0 PWL(0 0 2e-10 0 2.16667e-10 0.7 6e-10 0.7 6.16667e-10 0)
X18 vdd vdd 0 vdd in18 y18 vdd 0 gt2_6t_oai221_w31_lvt
CL18 y18 0 0.2f
VIN19 in19 0 PWL(0 0 2e-10 0 2.16667e-10 0.7 6e-10 0.7 6.16667e-10 0)
X19 vdd vdd vdd 0 in19 y19 vdd 0 gt2_6t_oai221_w31_lvt
CL19 y19 0 0.2f
VIN20 in20 0 PWL(0 0 2e-10 0 2.16667e-10 0.7 6e-10 0.7 6.16667e-10 0)
X20 vdd vdd vdd vdd in20 y20 vdd 0 gt2_6t_oai221_w31_lvt
CL20 y20 0 0.2f
.TRAN 0.5p 1n 0 1p
.PRINT TRAN FORMAT=CSV V(in0) V(y0) I(VIN0) V(in1) V(y1) I(VIN1) V(in2) V(y2) I(VIN2) V(in3) V(y3) I(VIN3) V(in4) V(y4) I(VIN4) V(in5) V(y5) I(VIN5) V(in6) V(y6) I(VIN6) V(in7) V(y7) I(VIN7) V(in8) V(y8) I(VIN8) V(in9) V(y9) I(VIN9) V(in10) V(y10) I(VIN10) V(in11) V(y11) I(VIN11) V(in12) V(y12) I(VIN12) V(in13) V(y13) I(VIN13) V(in14) V(y14) I(VIN14) V(in15) V(y15) I(VIN15) V(in16) V(y16) I(VIN16) V(in17) V(y17) I(VIN17) V(in18) V(y18) I(VIN18) V(in19) V(y19) I(VIN19) V(in20) V(y20) I(VIN20)
.END
