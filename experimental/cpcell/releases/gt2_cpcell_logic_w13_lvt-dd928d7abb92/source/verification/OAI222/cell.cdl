.SUBCKT gt2_6t_oai222_w13_lvt A1 A2 B1 B2 C1 C2 Y vdd vss
MNA0 Y A1 N1 vss nmos_lvt W=0.013u L=0.014u M=1
MNA1 Y A2 N1 vss nmos_lvt W=0.013u L=0.014u M=1
MPA0 Y A1 PA1 vdd pmos_lvt W=0.013u L=0.014u M=1
MPA1 PA1 A2 vdd vdd pmos_lvt W=0.013u L=0.014u M=1
MNB0 N1 B1 N2 vss nmos_lvt W=0.013u L=0.014u M=1
MNB1 N1 B2 N2 vss nmos_lvt W=0.013u L=0.014u M=1
MPB0 Y B1 PB1 vdd pmos_lvt W=0.013u L=0.014u M=1
MPB1 PB1 B2 vdd vdd pmos_lvt W=0.013u L=0.014u M=1
MNC0 N2 C1 vss vss nmos_lvt W=0.013u L=0.014u M=1
MNC1 N2 C2 vss vss nmos_lvt W=0.013u L=0.014u M=1
MPC0 Y C1 PC1 vdd pmos_lvt W=0.013u L=0.014u M=1
MPC1 PC1 C2 vdd vdd pmos_lvt W=0.013u L=0.014u M=1
.ENDS gt2_6t_oai222_w13_lvt
