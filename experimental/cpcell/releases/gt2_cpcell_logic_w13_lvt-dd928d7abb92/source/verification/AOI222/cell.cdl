.SUBCKT gt2_6t_aoi222_w13_lvt A1 A2 B1 B2 C1 C2 Y vdd vss
MNA0 Y A1 NA1 vss nmos_lvt W=0.013u L=0.014u M=1
MNA1 NA1 A2 vss vss nmos_lvt W=0.013u L=0.014u M=1
MPA0 Y A1 P1 vdd pmos_lvt W=0.013u L=0.014u M=1
MPA1 Y A2 P1 vdd pmos_lvt W=0.013u L=0.014u M=1
MNB0 Y B1 NB1 vss nmos_lvt W=0.013u L=0.014u M=1
MNB1 NB1 B2 vss vss nmos_lvt W=0.013u L=0.014u M=1
MPB0 P1 B1 P2 vdd pmos_lvt W=0.013u L=0.014u M=1
MPB1 P1 B2 P2 vdd pmos_lvt W=0.013u L=0.014u M=1
MNC0 Y C1 NC1 vss nmos_lvt W=0.013u L=0.014u M=1
MNC1 NC1 C2 vss vss nmos_lvt W=0.013u L=0.014u M=1
MPC0 P2 C1 vdd vdd pmos_lvt W=0.013u L=0.014u M=1
MPC1 P2 C2 vdd vdd pmos_lvt W=0.013u L=0.014u M=1
.ENDS gt2_6t_aoi222_w13_lvt
