.SUBCKT gt2_6t_or4_w13_lvt A B C D Y vdd vss
MN0 Z A vss vss nmos_lvt W=0.013u L=0.014u M=1
MN1 Z B vss vss nmos_lvt W=0.013u L=0.014u M=1
MN2 Z C vss vss nmos_lvt W=0.013u L=0.014u M=1
MN3 Z D vss vss nmos_lvt W=0.013u L=0.014u M=1
MP0 Z A P1 vdd pmos_lvt W=0.013u L=0.014u M=1
MP1 P1 B P2 vdd pmos_lvt W=0.013u L=0.014u M=1
MP2 P2 C P3 vdd pmos_lvt W=0.013u L=0.014u M=1
MP3 P3 D vdd vdd pmos_lvt W=0.013u L=0.014u M=1
MINV_N Y Z vss vss nmos_lvt W=0.013u L=0.014u M=1
MINV_P Y Z vdd vdd pmos_lvt W=0.013u L=0.014u M=1
.ENDS gt2_6t_or4_w13_lvt
