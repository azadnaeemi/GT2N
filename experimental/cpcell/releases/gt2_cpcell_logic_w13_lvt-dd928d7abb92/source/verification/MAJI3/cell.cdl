.SUBCKT gt2_6t_maji3_w13_lvt A B C Y vdd vss
MNAB0 Y A NAB1 vss nmos_lvt W=0.013u L=0.014u M=1
MNAB1 NAB1 B vss vss nmos_lvt W=0.013u L=0.014u M=1
MNC Y C N1 vss nmos_lvt W=0.013u L=0.014u M=1
MNP0 N1 A vss vss nmos_lvt W=0.013u L=0.014u M=1
MNP1 N1 B vss vss nmos_lvt W=0.013u L=0.014u M=1
MPP0 Y A P1 vdd pmos_lvt W=0.013u L=0.014u M=1
MPP1 Y B P1 vdd pmos_lvt W=0.013u L=0.014u M=1
MPC P1 C vdd vdd pmos_lvt W=0.013u L=0.014u M=1
MPAB0 P1 A PAB1 vdd pmos_lvt W=0.013u L=0.014u M=1
MPAB1 PAB1 B vdd vdd pmos_lvt W=0.013u L=0.014u M=1
.ENDS gt2_6t_maji3_w13_lvt
