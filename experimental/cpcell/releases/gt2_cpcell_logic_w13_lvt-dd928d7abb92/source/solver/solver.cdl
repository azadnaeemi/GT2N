.SUBCKT AND4 A B C D Y VDD VSS
MN0 Z A N1 VSS nmos w=46n l=14n nfin=2
MN1 N1 B N2 VSS nmos w=46n l=14n nfin=2
MN2 N2 C N3 VSS nmos w=46n l=14n nfin=2
MN3 N3 D VSS VSS nmos w=46n l=14n nfin=2
MP0 Z A VDD VDD pmos w=46n l=14n nfin=2
MP1 Z B VDD VDD pmos w=46n l=14n nfin=2
MP2 Z C VDD VDD pmos w=46n l=14n nfin=2
MP3 Z D VDD VDD pmos w=46n l=14n nfin=2
MINV_N Y Z VSS VSS nmos w=46n l=14n nfin=2
MINV_P Y Z VDD VDD pmos w=46n l=14n nfin=2
.ENDS AND4

.SUBCKT AND5 A B C D E Y VDD VSS
MN0 Z A N1 VSS nmos w=46n l=14n nfin=2
MN1 N1 B N2 VSS nmos w=46n l=14n nfin=2
MN2 N2 C N3 VSS nmos w=46n l=14n nfin=2
MN3 N3 D N4 VSS nmos w=46n l=14n nfin=2
MN4 N4 E VSS VSS nmos w=46n l=14n nfin=2
MP0 Z A VDD VDD pmos w=46n l=14n nfin=2
MP1 Z B VDD VDD pmos w=46n l=14n nfin=2
MP2 Z C VDD VDD pmos w=46n l=14n nfin=2
MP3 Z D VDD VDD pmos w=46n l=14n nfin=2
MP4 Z E VDD VDD pmos w=46n l=14n nfin=2
MINV_N Y Z VSS VSS nmos w=46n l=14n nfin=2
MINV_P Y Z VDD VDD pmos w=46n l=14n nfin=2
.ENDS AND5

.SUBCKT AO221 A1 A2 B1 B2 C Y VDD VSS
MNA0 Z A1 NA1 VSS nmos w=46n l=14n nfin=2
MNA1 NA1 A2 VSS VSS nmos w=46n l=14n nfin=2
MNB0 Z B1 NB1 VSS nmos w=46n l=14n nfin=2
MNB1 NB1 B2 VSS VSS nmos w=46n l=14n nfin=2
MNC Z C VSS VSS nmos w=46n l=14n nfin=2
MPA0 Z A1 P1 VDD pmos w=46n l=14n nfin=2
MPA1 Z A2 P1 VDD pmos w=46n l=14n nfin=2
MPB0 P1 B1 P2 VDD pmos w=46n l=14n nfin=2
MPB1 P1 B2 P2 VDD pmos w=46n l=14n nfin=2
MPC P2 C VDD VDD pmos w=46n l=14n nfin=2
MINV_N Y Z VSS VSS nmos w=46n l=14n nfin=2
MINV_P Y Z VDD VDD pmos w=46n l=14n nfin=2
.ENDS AO221

.SUBCKT AO222 A1 A2 B1 B2 C1 C2 Y VDD VSS
MNA0 Z A1 NA1 VSS nmos w=46n l=14n nfin=2
MNA1 NA1 A2 VSS VSS nmos w=46n l=14n nfin=2
MPA0 Z A1 P1 VDD pmos w=46n l=14n nfin=2
MPA1 Z A2 P1 VDD pmos w=46n l=14n nfin=2
MNB0 Z B1 NB1 VSS nmos w=46n l=14n nfin=2
MNB1 NB1 B2 VSS VSS nmos w=46n l=14n nfin=2
MPB0 P1 B1 P2 VDD pmos w=46n l=14n nfin=2
MPB1 P1 B2 P2 VDD pmos w=46n l=14n nfin=2
MNC0 Z C1 NC1 VSS nmos w=46n l=14n nfin=2
MNC1 NC1 C2 VSS VSS nmos w=46n l=14n nfin=2
MPC0 P2 C1 VDD VDD pmos w=46n l=14n nfin=2
MPC1 P2 C2 VDD VDD pmos w=46n l=14n nfin=2
MINV_N Y Z VSS VSS nmos w=46n l=14n nfin=2
MINV_P Y Z VDD VDD pmos w=46n l=14n nfin=2
.ENDS AO222

.SUBCKT AOI221 A1 A2 B1 B2 C Y VDD VSS
MNA0 Y A1 NA1 VSS nmos w=46n l=14n nfin=2
MNA1 NA1 A2 VSS VSS nmos w=46n l=14n nfin=2
MNB0 Y B1 NB1 VSS nmos w=46n l=14n nfin=2
MNB1 NB1 B2 VSS VSS nmos w=46n l=14n nfin=2
MNC Y C VSS VSS nmos w=46n l=14n nfin=2
MPA0 Y A1 P1 VDD pmos w=46n l=14n nfin=2
MPA1 Y A2 P1 VDD pmos w=46n l=14n nfin=2
MPB0 P1 B1 P2 VDD pmos w=46n l=14n nfin=2
MPB1 P1 B2 P2 VDD pmos w=46n l=14n nfin=2
MPC P2 C VDD VDD pmos w=46n l=14n nfin=2
.ENDS AOI221

.SUBCKT AOI222 A1 A2 B1 B2 C1 C2 Y VDD VSS
MNA0 Y A1 NA1 VSS nmos w=46n l=14n nfin=2
MNA1 NA1 A2 VSS VSS nmos w=46n l=14n nfin=2
MPA0 Y A1 P1 VDD pmos w=46n l=14n nfin=2
MPA1 Y A2 P1 VDD pmos w=46n l=14n nfin=2
MNB0 Y B1 NB1 VSS nmos w=46n l=14n nfin=2
MNB1 NB1 B2 VSS VSS nmos w=46n l=14n nfin=2
MPB0 P1 B1 P2 VDD pmos w=46n l=14n nfin=2
MPB1 P1 B2 P2 VDD pmos w=46n l=14n nfin=2
MNC0 Y C1 NC1 VSS nmos w=46n l=14n nfin=2
MNC1 NC1 C2 VSS VSS nmos w=46n l=14n nfin=2
MPC0 P2 C1 VDD VDD pmos w=46n l=14n nfin=2
MPC1 P2 C2 VDD VDD pmos w=46n l=14n nfin=2
.ENDS AOI222

.SUBCKT MAJ3 A B C Y VDD VSS
MNAB0 Z A NAB1 VSS nmos w=46n l=14n nfin=2
MNAB1 NAB1 B VSS VSS nmos w=46n l=14n nfin=2
MNC Z C N1 VSS nmos w=46n l=14n nfin=2
MNP0 N1 A VSS VSS nmos w=46n l=14n nfin=2
MNP1 N1 B VSS VSS nmos w=46n l=14n nfin=2
MPP0 Z A P1 VDD pmos w=46n l=14n nfin=2
MPP1 Z B P1 VDD pmos w=46n l=14n nfin=2
MPC P1 C VDD VDD pmos w=46n l=14n nfin=2
MPAB0 P1 A PAB1 VDD pmos w=46n l=14n nfin=2
MPAB1 PAB1 B VDD VDD pmos w=46n l=14n nfin=2
MINV_N Y Z VSS VSS nmos w=46n l=14n nfin=2
MINV_P Y Z VDD VDD pmos w=46n l=14n nfin=2
.ENDS MAJ3

.SUBCKT MAJI3 A B C Y VDD VSS
MNAB0 Y A NAB1 VSS nmos w=46n l=14n nfin=2
MNAB1 NAB1 B VSS VSS nmos w=46n l=14n nfin=2
MNC Y C N1 VSS nmos w=46n l=14n nfin=2
MNP0 N1 A VSS VSS nmos w=46n l=14n nfin=2
MNP1 N1 B VSS VSS nmos w=46n l=14n nfin=2
MPP0 Y A P1 VDD pmos w=46n l=14n nfin=2
MPP1 Y B P1 VDD pmos w=46n l=14n nfin=2
MPC P1 C VDD VDD pmos w=46n l=14n nfin=2
MPAB0 P1 A PAB1 VDD pmos w=46n l=14n nfin=2
MPAB1 PAB1 B VDD VDD pmos w=46n l=14n nfin=2
.ENDS MAJI3

.SUBCKT NAND4 A B C D Y VDD VSS
MN0 Y A N1 VSS nmos w=46n l=14n nfin=2
MN1 N1 B N2 VSS nmos w=46n l=14n nfin=2
MN2 N2 C N3 VSS nmos w=46n l=14n nfin=2
MN3 N3 D VSS VSS nmos w=46n l=14n nfin=2
MP0 Y A VDD VDD pmos w=46n l=14n nfin=2
MP1 Y B VDD VDD pmos w=46n l=14n nfin=2
MP2 Y C VDD VDD pmos w=46n l=14n nfin=2
MP3 Y D VDD VDD pmos w=46n l=14n nfin=2
.ENDS NAND4

.SUBCKT NAND5 A B C D E Y VDD VSS
MN0 Y A N1 VSS nmos w=46n l=14n nfin=2
MN1 N1 B N2 VSS nmos w=46n l=14n nfin=2
MN2 N2 C N3 VSS nmos w=46n l=14n nfin=2
MN3 N3 D N4 VSS nmos w=46n l=14n nfin=2
MN4 N4 E VSS VSS nmos w=46n l=14n nfin=2
MP0 Y A VDD VDD pmos w=46n l=14n nfin=2
MP1 Y B VDD VDD pmos w=46n l=14n nfin=2
MP2 Y C VDD VDD pmos w=46n l=14n nfin=2
MP3 Y D VDD VDD pmos w=46n l=14n nfin=2
MP4 Y E VDD VDD pmos w=46n l=14n nfin=2
.ENDS NAND5

.SUBCKT NOR4 A B C D Y VDD VSS
MN0 Y A VSS VSS nmos w=46n l=14n nfin=2
MN1 Y B VSS VSS nmos w=46n l=14n nfin=2
MN2 Y C VSS VSS nmos w=46n l=14n nfin=2
MN3 Y D VSS VSS nmos w=46n l=14n nfin=2
MP0 Y A P1 VDD pmos w=46n l=14n nfin=2
MP1 P1 B P2 VDD pmos w=46n l=14n nfin=2
MP2 P2 C P3 VDD pmos w=46n l=14n nfin=2
MP3 P3 D VDD VDD pmos w=46n l=14n nfin=2
.ENDS NOR4

.SUBCKT NOR5 A B C D E Y VDD VSS
MN0 Y A VSS VSS nmos w=46n l=14n nfin=2
MN1 Y B VSS VSS nmos w=46n l=14n nfin=2
MN2 Y C VSS VSS nmos w=46n l=14n nfin=2
MN3 Y D VSS VSS nmos w=46n l=14n nfin=2
MN4 Y E VSS VSS nmos w=46n l=14n nfin=2
MP0 Y A P1 VDD pmos w=46n l=14n nfin=2
MP1 P1 B P2 VDD pmos w=46n l=14n nfin=2
MP2 P2 C P3 VDD pmos w=46n l=14n nfin=2
MP3 P3 D P4 VDD pmos w=46n l=14n nfin=2
MP4 P4 E VDD VDD pmos w=46n l=14n nfin=2
.ENDS NOR5

.SUBCKT OA221 A1 A2 B1 B2 C Y VDD VSS
MNA0 Z A1 N1 VSS nmos w=46n l=14n nfin=2
MNA1 Z A2 N1 VSS nmos w=46n l=14n nfin=2
MNB0 N1 B1 N2 VSS nmos w=46n l=14n nfin=2
MNB1 N1 B2 N2 VSS nmos w=46n l=14n nfin=2
MNC N2 C VSS VSS nmos w=46n l=14n nfin=2
MPA0 Z A1 PA1 VDD pmos w=46n l=14n nfin=2
MPA1 PA1 A2 VDD VDD pmos w=46n l=14n nfin=2
MPB0 Z B1 PB1 VDD pmos w=46n l=14n nfin=2
MPB1 PB1 B2 VDD VDD pmos w=46n l=14n nfin=2
MPC Z C VDD VDD pmos w=46n l=14n nfin=2
MINV_N Y Z VSS VSS nmos w=46n l=14n nfin=2
MINV_P Y Z VDD VDD pmos w=46n l=14n nfin=2
.ENDS OA221

.SUBCKT OA222 A1 A2 B1 B2 C1 C2 Y VDD VSS
MNA0 Z A1 N1 VSS nmos w=46n l=14n nfin=2
MNA1 Z A2 N1 VSS nmos w=46n l=14n nfin=2
MPA0 Z A1 PA1 VDD pmos w=46n l=14n nfin=2
MPA1 PA1 A2 VDD VDD pmos w=46n l=14n nfin=2
MNB0 N1 B1 N2 VSS nmos w=46n l=14n nfin=2
MNB1 N1 B2 N2 VSS nmos w=46n l=14n nfin=2
MPB0 Z B1 PB1 VDD pmos w=46n l=14n nfin=2
MPB1 PB1 B2 VDD VDD pmos w=46n l=14n nfin=2
MNC0 N2 C1 VSS VSS nmos w=46n l=14n nfin=2
MNC1 N2 C2 VSS VSS nmos w=46n l=14n nfin=2
MPC0 Z C1 PC1 VDD pmos w=46n l=14n nfin=2
MPC1 PC1 C2 VDD VDD pmos w=46n l=14n nfin=2
MINV_N Y Z VSS VSS nmos w=46n l=14n nfin=2
MINV_P Y Z VDD VDD pmos w=46n l=14n nfin=2
.ENDS OA222

.SUBCKT OAI221 A1 A2 B1 B2 C Y VDD VSS
MNA0 Y A1 N1 VSS nmos w=46n l=14n nfin=2
MNA1 Y A2 N1 VSS nmos w=46n l=14n nfin=2
MNB0 N1 B1 N2 VSS nmos w=46n l=14n nfin=2
MNB1 N1 B2 N2 VSS nmos w=46n l=14n nfin=2
MNC N2 C VSS VSS nmos w=46n l=14n nfin=2
MPA0 Y A1 PA1 VDD pmos w=46n l=14n nfin=2
MPA1 PA1 A2 VDD VDD pmos w=46n l=14n nfin=2
MPB0 Y B1 PB1 VDD pmos w=46n l=14n nfin=2
MPB1 PB1 B2 VDD VDD pmos w=46n l=14n nfin=2
MPC Y C VDD VDD pmos w=46n l=14n nfin=2
.ENDS OAI221

.SUBCKT OAI222 A1 A2 B1 B2 C1 C2 Y VDD VSS
MNA0 Y A1 N1 VSS nmos w=46n l=14n nfin=2
MNA1 Y A2 N1 VSS nmos w=46n l=14n nfin=2
MPA0 Y A1 PA1 VDD pmos w=46n l=14n nfin=2
MPA1 PA1 A2 VDD VDD pmos w=46n l=14n nfin=2
MNB0 N1 B1 N2 VSS nmos w=46n l=14n nfin=2
MNB1 N1 B2 N2 VSS nmos w=46n l=14n nfin=2
MPB0 Y B1 PB1 VDD pmos w=46n l=14n nfin=2
MPB1 PB1 B2 VDD VDD pmos w=46n l=14n nfin=2
MNC0 N2 C1 VSS VSS nmos w=46n l=14n nfin=2
MNC1 N2 C2 VSS VSS nmos w=46n l=14n nfin=2
MPC0 Y C1 PC1 VDD pmos w=46n l=14n nfin=2
MPC1 PC1 C2 VDD VDD pmos w=46n l=14n nfin=2
.ENDS OAI222

.SUBCKT OR4 A B C D Y VDD VSS
MN0 Z A VSS VSS nmos w=46n l=14n nfin=2
MN1 Z B VSS VSS nmos w=46n l=14n nfin=2
MN2 Z C VSS VSS nmos w=46n l=14n nfin=2
MN3 Z D VSS VSS nmos w=46n l=14n nfin=2
MP0 Z A P1 VDD pmos w=46n l=14n nfin=2
MP1 P1 B P2 VDD pmos w=46n l=14n nfin=2
MP2 P2 C P3 VDD pmos w=46n l=14n nfin=2
MP3 P3 D VDD VDD pmos w=46n l=14n nfin=2
MINV_N Y Z VSS VSS nmos w=46n l=14n nfin=2
MINV_P Y Z VDD VDD pmos w=46n l=14n nfin=2
.ENDS OR4

.SUBCKT OR5 A B C D E Y VDD VSS
MN0 Z A VSS VSS nmos w=46n l=14n nfin=2
MN1 Z B VSS VSS nmos w=46n l=14n nfin=2
MN2 Z C VSS VSS nmos w=46n l=14n nfin=2
MN3 Z D VSS VSS nmos w=46n l=14n nfin=2
MN4 Z E VSS VSS nmos w=46n l=14n nfin=2
MP0 Z A P1 VDD pmos w=46n l=14n nfin=2
MP1 P1 B P2 VDD pmos w=46n l=14n nfin=2
MP2 P2 C P3 VDD pmos w=46n l=14n nfin=2
MP3 P3 D P4 VDD pmos w=46n l=14n nfin=2
MP4 P4 E VDD VDD pmos w=46n l=14n nfin=2
MINV_N Y Z VSS VSS nmos w=46n l=14n nfin=2
MINV_P Y Z VDD VDD pmos w=46n l=14n nfin=2
.ENDS OR5
