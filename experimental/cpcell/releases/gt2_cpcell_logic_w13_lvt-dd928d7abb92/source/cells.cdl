.SUBCKT gt2_6t_and4_w13_lvt A B C D Y vdd vss
MN0 Z A N1 vss nmos_lvt W=0.013u L=0.014u M=1
MN1 N1 B N2 vss nmos_lvt W=0.013u L=0.014u M=1
MN2 N2 C N3 vss nmos_lvt W=0.013u L=0.014u M=1
MN3 N3 D vss vss nmos_lvt W=0.013u L=0.014u M=1
MP0 Z A vdd vdd pmos_lvt W=0.013u L=0.014u M=1
MP1 Z B vdd vdd pmos_lvt W=0.013u L=0.014u M=1
MP2 Z C vdd vdd pmos_lvt W=0.013u L=0.014u M=1
MP3 Z D vdd vdd pmos_lvt W=0.013u L=0.014u M=1
MINV_N Y Z vss vss nmos_lvt W=0.013u L=0.014u M=1
MINV_P Y Z vdd vdd pmos_lvt W=0.013u L=0.014u M=1
.ENDS gt2_6t_and4_w13_lvt

.SUBCKT gt2_6t_and5_w13_lvt A B C D E Y vdd vss
MN0 Z A N1 vss nmos_lvt W=0.013u L=0.014u M=1
MN1 N1 B N2 vss nmos_lvt W=0.013u L=0.014u M=1
MN2 N2 C N3 vss nmos_lvt W=0.013u L=0.014u M=1
MN3 N3 D N4 vss nmos_lvt W=0.013u L=0.014u M=1
MN4 N4 E vss vss nmos_lvt W=0.013u L=0.014u M=1
MP0 Z A vdd vdd pmos_lvt W=0.013u L=0.014u M=1
MP1 Z B vdd vdd pmos_lvt W=0.013u L=0.014u M=1
MP2 Z C vdd vdd pmos_lvt W=0.013u L=0.014u M=1
MP3 Z D vdd vdd pmos_lvt W=0.013u L=0.014u M=1
MP4 Z E vdd vdd pmos_lvt W=0.013u L=0.014u M=1
MINV_N Y Z vss vss nmos_lvt W=0.013u L=0.014u M=1
MINV_P Y Z vdd vdd pmos_lvt W=0.013u L=0.014u M=1
.ENDS gt2_6t_and5_w13_lvt

.SUBCKT gt2_6t_ao221_w13_lvt A1 A2 B1 B2 C Y vdd vss
MNA0 Z A1 NA1 vss nmos_lvt W=0.013u L=0.014u M=1
MNA1 NA1 A2 vss vss nmos_lvt W=0.013u L=0.014u M=1
MNB0 Z B1 NB1 vss nmos_lvt W=0.013u L=0.014u M=1
MNB1 NB1 B2 vss vss nmos_lvt W=0.013u L=0.014u M=1
MNC Z C vss vss nmos_lvt W=0.013u L=0.014u M=1
MPA0 Z A1 P1 vdd pmos_lvt W=0.013u L=0.014u M=1
MPA1 Z A2 P1 vdd pmos_lvt W=0.013u L=0.014u M=1
MPB0 P1 B1 P2 vdd pmos_lvt W=0.013u L=0.014u M=1
MPB1 P1 B2 P2 vdd pmos_lvt W=0.013u L=0.014u M=1
MPC P2 C vdd vdd pmos_lvt W=0.013u L=0.014u M=1
MINV_N Y Z vss vss nmos_lvt W=0.013u L=0.014u M=1
MINV_P Y Z vdd vdd pmos_lvt W=0.013u L=0.014u M=1
.ENDS gt2_6t_ao221_w13_lvt

.SUBCKT gt2_6t_ao222_w13_lvt A1 A2 B1 B2 C1 C2 Y vdd vss
MNA0 Z A1 NA1 vss nmos_lvt W=0.013u L=0.014u M=1
MNA1 NA1 A2 vss vss nmos_lvt W=0.013u L=0.014u M=1
MPA0 Z A1 P1 vdd pmos_lvt W=0.013u L=0.014u M=1
MPA1 Z A2 P1 vdd pmos_lvt W=0.013u L=0.014u M=1
MNB0 Z B1 NB1 vss nmos_lvt W=0.013u L=0.014u M=1
MNB1 NB1 B2 vss vss nmos_lvt W=0.013u L=0.014u M=1
MPB0 P1 B1 P2 vdd pmos_lvt W=0.013u L=0.014u M=1
MPB1 P1 B2 P2 vdd pmos_lvt W=0.013u L=0.014u M=1
MNC0 Z C1 NC1 vss nmos_lvt W=0.013u L=0.014u M=1
MNC1 NC1 C2 vss vss nmos_lvt W=0.013u L=0.014u M=1
MPC0 P2 C1 vdd vdd pmos_lvt W=0.013u L=0.014u M=1
MPC1 P2 C2 vdd vdd pmos_lvt W=0.013u L=0.014u M=1
MINV_N Y Z vss vss nmos_lvt W=0.013u L=0.014u M=1
MINV_P Y Z vdd vdd pmos_lvt W=0.013u L=0.014u M=1
.ENDS gt2_6t_ao222_w13_lvt

.SUBCKT gt2_6t_aoi221_w13_lvt A1 A2 B1 B2 C Y vdd vss
MNA0 Y A1 NA1 vss nmos_lvt W=0.013u L=0.014u M=1
MNA1 NA1 A2 vss vss nmos_lvt W=0.013u L=0.014u M=1
MNB0 Y B1 NB1 vss nmos_lvt W=0.013u L=0.014u M=1
MNB1 NB1 B2 vss vss nmos_lvt W=0.013u L=0.014u M=1
MNC Y C vss vss nmos_lvt W=0.013u L=0.014u M=1
MPA0 Y A1 P1 vdd pmos_lvt W=0.013u L=0.014u M=1
MPA1 Y A2 P1 vdd pmos_lvt W=0.013u L=0.014u M=1
MPB0 P1 B1 P2 vdd pmos_lvt W=0.013u L=0.014u M=1
MPB1 P1 B2 P2 vdd pmos_lvt W=0.013u L=0.014u M=1
MPC P2 C vdd vdd pmos_lvt W=0.013u L=0.014u M=1
.ENDS gt2_6t_aoi221_w13_lvt

.SUBCKT gt2_6t_aoi222_w13_lvt A1 A2 B1 B2 C1 C2 Y vdd vss
MNA0 Y A1 NA1 vss nmos_lvt W=0.013u L=0.014u M=1
MNA1 NA1 A2 vss vss nmos_lvt W=0.013u L=0.014u M=1
MPA0 Y A1 P1 vdd pmos_lvt W=0.013u L=0.014u M=1
MPA1 Y A2 P1 vdd pmos_lvt W=0.013u L=0.014u M=1
MNB0 Y B1 NB1 vss nmos_lvt W=0.013u L=0.014u M=1
MNB1 NB1 B2 vss vss nmos_lvt W=0.013u L=0.014u M=1
MPB0 P1 B1 P2 vdd pmos_lvt W=0.013u L=0.014u M=1
MPB1 P1 B2 P2 vdd pmos_lvt W=0.013u L=0.014u M=1
MNC0 Y C1 NC1 vss nmos_lvt W=0.013u L=0.014u M=1
MNC1 NC1 C2 vss vss nmos_lvt W=0.013u L=0.014u M=1
MPC0 P2 C1 vdd vdd pmos_lvt W=0.013u L=0.014u M=1
MPC1 P2 C2 vdd vdd pmos_lvt W=0.013u L=0.014u M=1
.ENDS gt2_6t_aoi222_w13_lvt

.SUBCKT gt2_6t_maj3_w13_lvt A B C Y vdd vss
MNAB0 Z A NAB1 vss nmos_lvt W=0.013u L=0.014u M=1
MNAB1 NAB1 B vss vss nmos_lvt W=0.013u L=0.014u M=1
MNC Z C N1 vss nmos_lvt W=0.013u L=0.014u M=1
MNP0 N1 A vss vss nmos_lvt W=0.013u L=0.014u M=1
MNP1 N1 B vss vss nmos_lvt W=0.013u L=0.014u M=1
MPP0 Z A P1 vdd pmos_lvt W=0.013u L=0.014u M=1
MPP1 Z B P1 vdd pmos_lvt W=0.013u L=0.014u M=1
MPC P1 C vdd vdd pmos_lvt W=0.013u L=0.014u M=1
MPAB0 P1 A PAB1 vdd pmos_lvt W=0.013u L=0.014u M=1
MPAB1 PAB1 B vdd vdd pmos_lvt W=0.013u L=0.014u M=1
MINV_N Y Z vss vss nmos_lvt W=0.013u L=0.014u M=1
MINV_P Y Z vdd vdd pmos_lvt W=0.013u L=0.014u M=1
.ENDS gt2_6t_maj3_w13_lvt

.SUBCKT gt2_6t_maji3_w13_lvt A B C Y vdd vss
MNAB0 Y A NAB1 vss nmos_lvt W=0.013u L=0.014u M=1
MNAB1 NAB1 B vss vss nmos_lvt W=0.013u L=0.014u M=1
MNC Y C N1 vss nmos_lvt W=0.013u L=0.014u M=1
MNP0 N1 A vss vss nmos_lvt W=0.013u L=0.014u M=1
MNP1 N1 B vss vss nmos_lvt W=0.013u L=0.014u M=1
MPP0 Y A P1 vdd pmos_lvt W=0.013u L=0.014u M=1
MPP1 Y B P1 vdd pmos_lvt W=0.013u L=0.014u M=1
MPC P1 C vdd vdd pmos_lvt W=0.013u L=0.014u M=1
MPAB0 P1 A PAB1 vdd pmos_lvt W=0.013u L=0.014u M=1
MPAB1 PAB1 B vdd vdd pmos_lvt W=0.013u L=0.014u M=1
.ENDS gt2_6t_maji3_w13_lvt

.SUBCKT gt2_6t_nand4_w13_lvt A B C D Y vdd vss
MN0 Y A N1 vss nmos_lvt W=0.013u L=0.014u M=1
MN1 N1 B N2 vss nmos_lvt W=0.013u L=0.014u M=1
MN2 N2 C N3 vss nmos_lvt W=0.013u L=0.014u M=1
MN3 N3 D vss vss nmos_lvt W=0.013u L=0.014u M=1
MP0 Y A vdd vdd pmos_lvt W=0.013u L=0.014u M=1
MP1 Y B vdd vdd pmos_lvt W=0.013u L=0.014u M=1
MP2 Y C vdd vdd pmos_lvt W=0.013u L=0.014u M=1
MP3 Y D vdd vdd pmos_lvt W=0.013u L=0.014u M=1
.ENDS gt2_6t_nand4_w13_lvt

.SUBCKT gt2_6t_nand5_w13_lvt A B C D E Y vdd vss
MN0 Y A N1 vss nmos_lvt W=0.013u L=0.014u M=1
MN1 N1 B N2 vss nmos_lvt W=0.013u L=0.014u M=1
MN2 N2 C N3 vss nmos_lvt W=0.013u L=0.014u M=1
MN3 N3 D N4 vss nmos_lvt W=0.013u L=0.014u M=1
MN4 N4 E vss vss nmos_lvt W=0.013u L=0.014u M=1
MP0 Y A vdd vdd pmos_lvt W=0.013u L=0.014u M=1
MP1 Y B vdd vdd pmos_lvt W=0.013u L=0.014u M=1
MP2 Y C vdd vdd pmos_lvt W=0.013u L=0.014u M=1
MP3 Y D vdd vdd pmos_lvt W=0.013u L=0.014u M=1
MP4 Y E vdd vdd pmos_lvt W=0.013u L=0.014u M=1
.ENDS gt2_6t_nand5_w13_lvt

.SUBCKT gt2_6t_nor4_w13_lvt A B C D Y vdd vss
MN0 Y A vss vss nmos_lvt W=0.013u L=0.014u M=1
MN1 Y B vss vss nmos_lvt W=0.013u L=0.014u M=1
MN2 Y C vss vss nmos_lvt W=0.013u L=0.014u M=1
MN3 Y D vss vss nmos_lvt W=0.013u L=0.014u M=1
MP0 Y A P1 vdd pmos_lvt W=0.013u L=0.014u M=1
MP1 P1 B P2 vdd pmos_lvt W=0.013u L=0.014u M=1
MP2 P2 C P3 vdd pmos_lvt W=0.013u L=0.014u M=1
MP3 P3 D vdd vdd pmos_lvt W=0.013u L=0.014u M=1
.ENDS gt2_6t_nor4_w13_lvt

.SUBCKT gt2_6t_nor5_w13_lvt A B C D E Y vdd vss
MN0 Y A vss vss nmos_lvt W=0.013u L=0.014u M=1
MN1 Y B vss vss nmos_lvt W=0.013u L=0.014u M=1
MN2 Y C vss vss nmos_lvt W=0.013u L=0.014u M=1
MN3 Y D vss vss nmos_lvt W=0.013u L=0.014u M=1
MN4 Y E vss vss nmos_lvt W=0.013u L=0.014u M=1
MP0 Y A P1 vdd pmos_lvt W=0.013u L=0.014u M=1
MP1 P1 B P2 vdd pmos_lvt W=0.013u L=0.014u M=1
MP2 P2 C P3 vdd pmos_lvt W=0.013u L=0.014u M=1
MP3 P3 D P4 vdd pmos_lvt W=0.013u L=0.014u M=1
MP4 P4 E vdd vdd pmos_lvt W=0.013u L=0.014u M=1
.ENDS gt2_6t_nor5_w13_lvt

.SUBCKT gt2_6t_oa221_w13_lvt A1 A2 B1 B2 C Y vdd vss
MNA0 Z A1 N1 vss nmos_lvt W=0.013u L=0.014u M=1
MNA1 Z A2 N1 vss nmos_lvt W=0.013u L=0.014u M=1
MNB0 N1 B1 N2 vss nmos_lvt W=0.013u L=0.014u M=1
MNB1 N1 B2 N2 vss nmos_lvt W=0.013u L=0.014u M=1
MNC N2 C vss vss nmos_lvt W=0.013u L=0.014u M=1
MPA0 Z A1 PA1 vdd pmos_lvt W=0.013u L=0.014u M=1
MPA1 PA1 A2 vdd vdd pmos_lvt W=0.013u L=0.014u M=1
MPB0 Z B1 PB1 vdd pmos_lvt W=0.013u L=0.014u M=1
MPB1 PB1 B2 vdd vdd pmos_lvt W=0.013u L=0.014u M=1
MPC Z C vdd vdd pmos_lvt W=0.013u L=0.014u M=1
MINV_N Y Z vss vss nmos_lvt W=0.013u L=0.014u M=1
MINV_P Y Z vdd vdd pmos_lvt W=0.013u L=0.014u M=1
.ENDS gt2_6t_oa221_w13_lvt

.SUBCKT gt2_6t_oa222_w13_lvt A1 A2 B1 B2 C1 C2 Y vdd vss
MNA0 Z A1 N1 vss nmos_lvt W=0.013u L=0.014u M=1
MNA1 Z A2 N1 vss nmos_lvt W=0.013u L=0.014u M=1
MPA0 Z A1 PA1 vdd pmos_lvt W=0.013u L=0.014u M=1
MPA1 PA1 A2 vdd vdd pmos_lvt W=0.013u L=0.014u M=1
MNB0 N1 B1 N2 vss nmos_lvt W=0.013u L=0.014u M=1
MNB1 N1 B2 N2 vss nmos_lvt W=0.013u L=0.014u M=1
MPB0 Z B1 PB1 vdd pmos_lvt W=0.013u L=0.014u M=1
MPB1 PB1 B2 vdd vdd pmos_lvt W=0.013u L=0.014u M=1
MNC0 N2 C1 vss vss nmos_lvt W=0.013u L=0.014u M=1
MNC1 N2 C2 vss vss nmos_lvt W=0.013u L=0.014u M=1
MPC0 Z C1 PC1 vdd pmos_lvt W=0.013u L=0.014u M=1
MPC1 PC1 C2 vdd vdd pmos_lvt W=0.013u L=0.014u M=1
MINV_N Y Z vss vss nmos_lvt W=0.013u L=0.014u M=1
MINV_P Y Z vdd vdd pmos_lvt W=0.013u L=0.014u M=1
.ENDS gt2_6t_oa222_w13_lvt

.SUBCKT gt2_6t_oai221_w13_lvt A1 A2 B1 B2 C Y vdd vss
MNA0 Y A1 N1 vss nmos_lvt W=0.013u L=0.014u M=1
MNA1 Y A2 N1 vss nmos_lvt W=0.013u L=0.014u M=1
MNB0 N1 B1 N2 vss nmos_lvt W=0.013u L=0.014u M=1
MNB1 N1 B2 N2 vss nmos_lvt W=0.013u L=0.014u M=1
MNC N2 C vss vss nmos_lvt W=0.013u L=0.014u M=1
MPA0 Y A1 PA1 vdd pmos_lvt W=0.013u L=0.014u M=1
MPA1 PA1 A2 vdd vdd pmos_lvt W=0.013u L=0.014u M=1
MPB0 Y B1 PB1 vdd pmos_lvt W=0.013u L=0.014u M=1
MPB1 PB1 B2 vdd vdd pmos_lvt W=0.013u L=0.014u M=1
MPC Y C vdd vdd pmos_lvt W=0.013u L=0.014u M=1
.ENDS gt2_6t_oai221_w13_lvt

.SUBCKT gt2_6t_oai222_w13_lvt A1 A2 B1 B2 C1 C2 Y vdd vss
MNA0 Y A1 N1 vss nmos_lvt W=0.013u L=0.014u M=1
MNA1 Y A2 N1 vss nmos_lvt W=0.013u L=0.014u M=1
MPA0 Y A1 PA1 vdd pmos_lvt W=0.013u L=0.014u M=1
MPA1 PA1 A2 vdd vdd pmos_lvt W=0.013u L=0.014u M=1
MNB0 N1 B1 N2 vss nmos_lvt W=0.013u L=0.014u M=1
MNB1 N1 B2 N2 vss nmos_lvt W=0.013u L=0.014u M=1
MPB0 Y B1 PB1 vdd pmos_lvt W=0.013u L=0.014u M=1
MPB1 PB1 B2 vdd vdd pmos_lvt W=0.013u L=0.014u M=1
MNC0 N2 C1 vss vss nmos_lvt W=0.013u L=0.014u M=1
MNC1 N2 C2 vss vss nmos_lvt W=0.013u L=0.014u M=1
MPC0 Y C1 PC1 vdd pmos_lvt W=0.013u L=0.014u M=1
MPC1 PC1 C2 vdd vdd pmos_lvt W=0.013u L=0.014u M=1
.ENDS gt2_6t_oai222_w13_lvt

.SUBCKT gt2_6t_or4_w13_lvt A B C D Y vdd vss
MN0 Z A vss vss nmos_lvt W=0.013u L=0.014u M=1
MN1 Z B vss vss nmos_lvt W=0.013u L=0.014u M=1
MN2 Z C vss vss nmos_lvt W=0.013u L=0.014u M=1
MN3 Z D vss vss nmos_lvt W=0.013u L=0.014u M=1
MP0 Z A P1 vdd pmos_lvt W=0.013u L=0.014u M=1
MP1 P1 B P2 vdd pmos_lvt W=0.013u L=0.014u M=1
MP2 P2 C P3 vdd pmos_lvt W=0.013u L=0.014u M=1
MP3 P3 D vdd vdd pmos_lvt W=0.013u L=0.014u M=1
MINV_N Y Z vss vss nmos_lvt W=0.013u L=0.014u M=1
MINV_P Y Z vdd vdd pmos_lvt W=0.013u L=0.014u M=1
.ENDS gt2_6t_or4_w13_lvt

.SUBCKT gt2_6t_or5_w13_lvt A B C D E Y vdd vss
MN0 Z A vss vss nmos_lvt W=0.013u L=0.014u M=1
MN1 Z B vss vss nmos_lvt W=0.013u L=0.014u M=1
MN2 Z C vss vss nmos_lvt W=0.013u L=0.014u M=1
MN3 Z D vss vss nmos_lvt W=0.013u L=0.014u M=1
MN4 Z E vss vss nmos_lvt W=0.013u L=0.014u M=1
MP0 Z A P1 vdd pmos_lvt W=0.013u L=0.014u M=1
MP1 P1 B P2 vdd pmos_lvt W=0.013u L=0.014u M=1
MP2 P2 C P3 vdd pmos_lvt W=0.013u L=0.014u M=1
MP3 P3 D P4 vdd pmos_lvt W=0.013u L=0.014u M=1
MP4 P4 E vdd vdd pmos_lvt W=0.013u L=0.014u M=1
MINV_N Y Z vss vss nmos_lvt W=0.013u L=0.014u M=1
MINV_P Y Z vdd vdd pmos_lvt W=0.013u L=0.014u M=1
.ENDS gt2_6t_or5_w13_lvt
